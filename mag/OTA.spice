** sch_path: /home/bingyao/Desktop/FCOTA/OTA.sch
.subckt OTA vdo vdd vss vip vin vout va vb vc
*.PININFO vdo:I vdd:B vss:B vip:I vin:I vout:O va:I vb:I vc:I
XM13 net3 vc net1 vss sky130_fd_pr__nfet_01v8 L=0.4 W=120 nf=10
XM14 vout vc net2 vss sky130_fd_pr__nfet_01v8 L=0.4 W=120 nf=10
XM15 net1 net3 vss vss sky130_fd_pr__nfet_01v8 L=0.4 W=9 nf=1
XM16 net2 net3 vss vss sky130_fd_pr__nfet_01v8 L=0.4 W=9 nf=1
XM17 net3 vb net5 vdd sky130_fd_pr__pfet_01v8 L=0.4 W=240 nf=20
XM18 vout vb net4 vdd sky130_fd_pr__pfet_01v8 L=0.4 W=240 nf=20
XM19 net4 va vdd vdd sky130_fd_pr__pfet_01v8 L=0.4 W=24 nf=6
XM20 net5 va vdd vdd sky130_fd_pr__pfet_01v8 L=0.4 W=24 nf=6
XM21 net5 vip net6 vss sky130_fd_pr__nfet_01v8 L=0.4 W=96 nf=8
XM22 net4 vin net6 vss sky130_fd_pr__nfet_01v8 L=0.4 W=96 nf=8
XM23 net6 net7 vss vss sky130_fd_pr__nfet_01v8 L=0.4 W=24 nf=2
XM24 net7 net7 vss vss sky130_fd_pr__nfet_01v8 L=0.4 W=1.6 nf=1
XM34 vdd vdo net7 vdd sky130_fd_pr__pfet_01v8 L=0.4 W=6 nf=1
.ends
