* NGSPICE file created from Beta_mult.ext - technology: sky130A

.subckt sky130_fd_pr__pfet_01v8_NMD27C G D B S
X0 S G D B sky130_fd_pr__pfet_01v8 ad=1.74 pd=12.58 as=1.74 ps=12.58 w=6 l=0.4
.ends

.subckt sky130_fd_pr__nfet_01v8_WVN3PK G D B S
X0 S G D B sky130_fd_pr__nfet_01v8 ad=2.32 pd=16.58 as=2.32 ps=16.58 w=8 l=0.4
.ends

.subckt sky130_fd_pr__nfet_01v8_8NR3P7 G D B S
X0 S G D B sky130_fd_pr__nfet_01v8 ad=0.58 pd=4.58 as=0.58 ps=4.58 w=2 l=0.4
.ends

.subckt sky130_fd_pr__pfet_01v8_B6MYM2 G D B S
X0 S G D B sky130_fd_pr__pfet_01v8 ad=0.58 pd=4.58 as=0.58 ps=4.58 w=2 l=20
.ends

.subckt sky130_fd_pr__res_xhigh_po_1p41_6MYZWV B R2 R1
X0 R1 R2 B sky130_fd_pr__res_xhigh_po_1p41 l=5.3
.ends

.subckt sky130_fd_pr__nfet_01v8_8SA9P7 G D B S
X0 S G D B sky130_fd_pr__nfet_01v8 ad=0.58 pd=4.58 as=0.58 ps=4.58 w=2 l=0.2
.ends

.subckt Beta_mult vss vdd
XXM25 vss vss vdd vdd sky130_fd_pr__pfet_01v8_NMD27C
XXM27 vss vss vss vss sky130_fd_pr__nfet_01v8_WVN3PK
XXM28 vss vss vss vss sky130_fd_pr__nfet_01v8_8NR3P7
XXM29 XM31/G XM31/G vdd vdd sky130_fd_pr__pfet_01v8_B6MYM2
Xsky130_fd_pr__res_xhigh_po_1p41_6MYZWV_0 vss vss vss sky130_fd_pr__res_xhigh_po_1p41_6MYZWV
XXM1 vss vss vdd vdd sky130_fd_pr__pfet_01v8_NMD27C
XXM30 vss XM31/G vss vss sky130_fd_pr__nfet_01v8_8NR3P7
XXM31 XM31/G vss vss XM31/S sky130_fd_pr__nfet_01v8_8SA9P7
.ends
