* NGSPICE file created from self_bias_FCOTA_flat.ext - technology: sky130A

.subckt self_bias_FCOTA_flat vout vdd vss vin vip
X0 vss Beta_mult_0.XM31.S Beta_mult_0.XM31.S vss sky130_fd_pr__nfet_01v8 ad=0.58 pd=4.58 as=0.58 ps=4.58 w=2 l=0.4
X1 OTA_0.XM21.D0 OTA_0.vb OTA_0.XM17.D0 vdd sky130_fd_pr__pfet_01v8 ad=1.74 pd=12.29 as=3.48 ps=24.58 w=12 l=0.4
X2 OTA_0.XM22.D0 OTA_0.vb vout vdd sky130_fd_pr__pfet_01v8 ad=1.74 pd=12.29 as=1.74 ps=12.29 w=12 l=0.4
X3 OTA_0.XM21.D0 OTA_0.vb OTA_0.XM17.D0 vdd sky130_fd_pr__pfet_01v8 ad=1.74 pd=12.29 as=1.74 ps=12.29 w=12 l=0.4
X4 OTA_0.vc OTA_0.vdo vdd vdd sky130_fd_pr__pfet_01v8 ad=1.74 pd=12.58 as=1.74 ps=12.58 w=6 l=0.4
X5 OTA_0.XM21.D0 OTA_0.vb OTA_0.XM17.D0 vdd sky130_fd_pr__pfet_01v8 ad=1.74 pd=12.29 as=1.74 ps=12.29 w=12 l=0.4
X6 vdd OTA_0.va OTA_0.XM22.D0 vdd sky130_fd_pr__pfet_01v8 ad=0.58 pd=4.29 as=0.58 ps=4.29 w=4 l=0.4
X7 OTA_0.XM21.D0 OTA_0.vb OTA_0.XM17.D0 vdd sky130_fd_pr__pfet_01v8 ad=1.74 pd=12.29 as=1.74 ps=12.29 w=12 l=0.4
X8 OTA_0.vb OTA_0.vb biasing_0.XM12.D vdd sky130_fd_pr__pfet_01v8 ad=2.32 pd=16.58 as=1.16 ps=8.29 w=8 l=0.4
X9 OTA_0.XM21.D0 OTA_0.va vdd vdd sky130_fd_pr__pfet_01v8 ad=0.58 pd=4.29 as=0.58 ps=4.29 w=4 l=0.4
X10 OTA_0.XM23.D0 OTA_0.XM34.S vss vss sky130_fd_pr__nfet_01v8 ad=3.48 pd=24.58 as=1.74 ps=12.29 w=12 l=0.4
X11 OTA_0.XM15.D OTA_0.XM17.D0 vss vss sky130_fd_pr__nfet_01v8 ad=2.61 pd=18.58 as=2.61 ps=18.58 w=9 l=0.4
X12 biasing_0.XM2.D OTA_0.vc OTA_0.vc vss sky130_fd_pr__nfet_01v8 ad=2.32 pd=16.58 as=2.32 ps=16.58 w=8 l=0.4
X13 vss biasing_0.VD biasing_0.XM4.D vss sky130_fd_pr__nfet_01v8 ad=0.174 pd=1.78 as=0.174 ps=1.78 w=0.6 l=0.4
X14 vout OTA_0.vb OTA_0.XM22.D0 vdd sky130_fd_pr__pfet_01v8 ad=1.74 pd=12.29 as=1.74 ps=12.29 w=12 l=0.4
X15 OTA_0.XM17.D0 OTA_0.vb OTA_0.XM21.D0 vdd sky130_fd_pr__pfet_01v8 ad=1.74 pd=12.29 as=1.74 ps=12.29 w=12 l=0.4
X16 OTA_0.XM16.D OTA_0.vc vout vss sky130_fd_pr__nfet_01v8 ad=1.74 pd=12.29 as=3.48 ps=24.58 w=12 l=0.4
X17 OTA_0.XM17.D0 OTA_0.vb OTA_0.XM21.D0 vdd sky130_fd_pr__pfet_01v8 ad=1.74 pd=12.29 as=1.74 ps=12.29 w=12 l=0.4
X18 vdd OTA_0.va OTA_0.XM21.D0 vdd sky130_fd_pr__pfet_01v8 ad=0.58 pd=4.29 as=0.58 ps=4.29 w=4 l=0.4
X19 vout OTA_0.vb OTA_0.XM22.D0 vdd sky130_fd_pr__pfet_01v8 ad=3.48 pd=24.58 as=1.74 ps=12.29 w=12 l=0.4
X20 vdd OTA_0.va OTA_0.XM22.D0 vdd sky130_fd_pr__pfet_01v8 ad=0.58 pd=4.29 as=0.58 ps=4.29 w=4 l=0.4
X21 vss biasing_0.VD biasing_0.XM6.D vss sky130_fd_pr__nfet_01v8 ad=0.174 pd=1.78 as=0.174 ps=1.78 w=0.6 l=0.4
X22 OTA_0.XM22.D0 OTA_0.vb vout vdd sky130_fd_pr__pfet_01v8 ad=1.74 pd=12.29 as=1.74 ps=12.29 w=12 l=0.4
X23 OTA_0.XM21.D0 OTA_0.vb OTA_0.XM17.D0 vdd sky130_fd_pr__pfet_01v8 ad=1.74 pd=12.29 as=1.74 ps=12.29 w=12 l=0.4
X24 OTA_0.XM17.D0 OTA_0.vc OTA_0.XM15.D vss sky130_fd_pr__nfet_01v8 ad=1.74 pd=12.29 as=1.74 ps=12.29 w=12 l=0.4
X25 OTA_0.XM22.D0 OTA_0.vb vout vdd sky130_fd_pr__pfet_01v8 ad=1.74 pd=12.29 as=1.74 ps=12.29 w=12 l=0.4
X26 OTA_0.XM22.D0 vin OTA_0.XM23.D0 vss sky130_fd_pr__nfet_01v8 ad=3.48 pd=24.58 as=1.74 ps=12.29 w=12 l=0.4
X27 OTA_0.XM21.D0 OTA_0.va vdd vdd sky130_fd_pr__pfet_01v8 ad=1.16 pd=8.58 as=0.58 ps=4.29 w=4 l=0.4
X28 vout OTA_0.vb OTA_0.XM22.D0 vdd sky130_fd_pr__pfet_01v8 ad=1.74 pd=12.29 as=1.74 ps=12.29 w=12 l=0.4
X29 vout OTA_0.vb OTA_0.XM22.D0 vdd sky130_fd_pr__pfet_01v8 ad=1.74 pd=12.29 as=1.74 ps=12.29 w=12 l=0.4
X30 vout OTA_0.vb OTA_0.XM22.D0 vdd sky130_fd_pr__pfet_01v8 ad=1.74 pd=12.29 as=1.74 ps=12.29 w=12 l=0.4
X31 OTA_0.XM17.D0 OTA_0.vb OTA_0.XM21.D0 vdd sky130_fd_pr__pfet_01v8 ad=1.74 pd=12.29 as=1.74 ps=12.29 w=12 l=0.4
X32 OTA_0.XM34.S OTA_0.vdo vdd vdd sky130_fd_pr__pfet_01v8 ad=1.74 pd=12.58 as=1.74 ps=12.58 w=6 l=0.4
X33 vdd OTA_0.vb biasing_0.XM12.D vdd sky130_fd_pr__pfet_01v8 ad=0.348 pd=2.98 as=0.348 ps=2.98 w=1.2 l=0.4
X34 vss OTA_0.vc biasing_0.XM2.D vss sky130_fd_pr__nfet_01v8 ad=0.174 pd=1.78 as=0.174 ps=1.78 w=0.6 l=0.4
X35 vout OTA_0.vb OTA_0.XM22.D0 vdd sky130_fd_pr__pfet_01v8 ad=1.74 pd=12.29 as=1.74 ps=12.29 w=12 l=0.4
X36 vdd OTA_0.va OTA_0.XM21.D0 vdd sky130_fd_pr__pfet_01v8 ad=0.58 pd=4.29 as=1.16 ps=8.58 w=4 l=0.4
X37 OTA_0.XM22.D0 OTA_0.vb vout vdd sky130_fd_pr__pfet_01v8 ad=1.74 pd=12.29 as=3.48 ps=24.58 w=12 l=0.4
X38 OTA_0.XM22.D0 OTA_0.vb vout vdd sky130_fd_pr__pfet_01v8 ad=1.74 pd=12.29 as=1.74 ps=12.29 w=12 l=0.4
X39 OTA_0.XM22.D0 OTA_0.vb vout vdd sky130_fd_pr__pfet_01v8 ad=1.74 pd=12.29 as=1.74 ps=12.29 w=12 l=0.4
X40 vdd OTA_0.va biasing_0.XM11.D vdd sky130_fd_pr__pfet_01v8 ad=0.348 pd=2.98 as=0.348 ps=2.98 w=1.2 l=0.4
X41 OTA_0.XM22.D0 vin OTA_0.XM23.D0 vss sky130_fd_pr__nfet_01v8 ad=1.74 pd=12.29 as=1.74 ps=12.29 w=12 l=0.4
X42 OTA_0.XM21.D0 vip OTA_0.XM23.D0 vss sky130_fd_pr__nfet_01v8 ad=1.74 pd=12.29 as=1.74 ps=12.29 w=12 l=0.4
X43 vout OTA_0.vb OTA_0.XM22.D0 vdd sky130_fd_pr__pfet_01v8 ad=1.74 pd=12.29 as=1.74 ps=12.29 w=12 l=0.4
X44 OTA_0.XM17.D0 OTA_0.vb OTA_0.XM21.D0 vdd sky130_fd_pr__pfet_01v8 ad=1.74 pd=12.29 as=1.74 ps=12.29 w=12 l=0.4
X45 vout OTA_0.vb OTA_0.XM22.D0 vdd sky130_fd_pr__pfet_01v8 ad=1.74 pd=12.29 as=1.74 ps=12.29 w=12 l=0.4
X46 OTA_0.XM23.D0 vin OTA_0.XM22.D0 vss sky130_fd_pr__nfet_01v8 ad=1.74 pd=12.29 as=3.48 ps=24.58 w=12 l=0.4
X47 OTA_0.XM23.D0 vin OTA_0.XM22.D0 vss sky130_fd_pr__nfet_01v8 ad=1.74 pd=12.29 as=1.74 ps=12.29 w=12 l=0.4
X48 OTA_0.XM22.D0 OTA_0.vb vout vdd sky130_fd_pr__pfet_01v8 ad=1.74 pd=12.29 as=1.74 ps=12.29 w=12 l=0.4
X49 OTA_0.XM22.D0 vin OTA_0.XM23.D0 vss sky130_fd_pr__nfet_01v8 ad=1.74 pd=12.29 as=1.74 ps=12.29 w=12 l=0.4
X50 OTA_0.XM22.D0 OTA_0.vb vout vdd sky130_fd_pr__pfet_01v8 ad=1.74 pd=12.29 as=1.74 ps=12.29 w=12 l=0.4
X51 OTA_0.XM21.D0 OTA_0.vb OTA_0.XM17.D0 vdd sky130_fd_pr__pfet_01v8 ad=1.74 pd=12.29 as=1.74 ps=12.29 w=12 l=0.4
X52 biasing_0.XM6.D OTA_0.vc OTA_0.va vss sky130_fd_pr__nfet_01v8 ad=2.32 pd=16.58 as=2.32 ps=16.58 w=8 l=0.4
X53 vdd OTA_0.vdo OTA_0.vdo vdd sky130_fd_pr__pfet_01v8 ad=1.74 pd=12.58 as=1.74 ps=12.58 w=6 l=0.4
X54 vss Beta_mult_0.XR1.R1 vss sky130_fd_pr__res_high_po_0p69 l=15
X55 OTA_0.XM22.D0 vin OTA_0.XM23.D0 vss sky130_fd_pr__nfet_01v8 ad=1.74 pd=12.29 as=1.74 ps=12.29 w=12 l=0.4
X56 biasing_0.VD OTA_0.vdo vdd vdd sky130_fd_pr__pfet_01v8 ad=1.74 pd=12.58 as=1.74 ps=12.58 w=6 l=0.4
X57 Beta_mult_0.XM31.S Beta_mult_0.XM31.G OTA_0.vdo vss sky130_fd_pr__nfet_01v8 ad=0.58 pd=4.58 as=0.58 ps=4.58 w=2 l=0.2
X58 vss Beta_mult_0.XM31.S Beta_mult_0.XM31.G vss sky130_fd_pr__nfet_01v8 ad=0.58 pd=4.58 as=0.58 ps=4.58 w=2 l=0.4
X59 OTA_0.XM23.D0 vin OTA_0.XM22.D0 vss sky130_fd_pr__nfet_01v8 ad=1.74 pd=12.29 as=1.74 ps=12.29 w=12 l=0.4
X60 biasing_0.XM12.D OTA_0.vb OTA_0.vb vdd sky130_fd_pr__pfet_01v8 ad=1.16 pd=8.29 as=2.32 ps=16.58 w=8 l=0.4
X61 OTA_0.va OTA_0.vb biasing_0.XM11.D vdd sky130_fd_pr__pfet_01v8 ad=2.32 pd=16.58 as=1.16 ps=8.29 w=8 l=0.4
X62 vss OTA_0.XM34.S OTA_0.XM23.D0 vss sky130_fd_pr__nfet_01v8 ad=1.74 pd=12.29 as=3.48 ps=24.58 w=12 l=0.4
X63 vout OTA_0.vb OTA_0.XM22.D0 vdd sky130_fd_pr__pfet_01v8 ad=1.74 pd=12.29 as=1.74 ps=12.29 w=12 l=0.4
X64 OTA_0.XM21.D0 OTA_0.vb OTA_0.XM17.D0 vdd sky130_fd_pr__pfet_01v8 ad=1.74 pd=12.29 as=1.74 ps=12.29 w=12 l=0.4
X65 OTA_0.XM23.D0 vin OTA_0.XM22.D0 vss sky130_fd_pr__nfet_01v8 ad=1.74 pd=12.29 as=1.74 ps=12.29 w=12 l=0.4
X66 vdd OTA_0.vdo Beta_mult_0.XM31.S vdd sky130_fd_pr__pfet_01v8 ad=1.74 pd=12.58 as=1.74 ps=12.58 w=6 l=0.4
X67 biasing_0.XM4.D OTA_0.vc biasing_0.VD vss sky130_fd_pr__nfet_01v8 ad=2.32 pd=16.58 as=2.32 ps=16.58 w=8 l=0.4
X68 OTA_0.XM15.D OTA_0.vc OTA_0.XM17.D0 vss sky130_fd_pr__nfet_01v8 ad=1.74 pd=12.29 as=1.74 ps=12.29 w=12 l=0.4
X69 OTA_0.XM22.D0 OTA_0.vb vout vdd sky130_fd_pr__pfet_01v8 ad=1.74 pd=12.29 as=1.74 ps=12.29 w=12 l=0.4
X70 OTA_0.XM17.D0 OTA_0.vb OTA_0.XM21.D0 vdd sky130_fd_pr__pfet_01v8 ad=1.74 pd=12.29 as=1.74 ps=12.29 w=12 l=0.4
X71 OTA_0.XM16.D OTA_0.XM17.D0 vss vss sky130_fd_pr__nfet_01v8 ad=2.61 pd=18.58 as=2.61 ps=18.58 w=9 l=0.4
X72 vdd OTA_0.va OTA_0.XM22.D0 vdd sky130_fd_pr__pfet_01v8 ad=0.58 pd=4.29 as=1.16 ps=8.58 w=4 l=0.4
X73 OTA_0.XM21.D0 vip OTA_0.XM23.D0 vss sky130_fd_pr__nfet_01v8 ad=1.74 pd=12.29 as=1.74 ps=12.29 w=12 l=0.4
X74 biasing_0.XM11.D OTA_0.vb OTA_0.va vdd sky130_fd_pr__pfet_01v8 ad=1.16 pd=8.29 as=2.32 ps=16.58 w=8 l=0.4
X75 OTA_0.XM17.D0 OTA_0.vc OTA_0.XM15.D vss sky130_fd_pr__nfet_01v8 ad=1.74 pd=12.29 as=1.74 ps=12.29 w=12 l=0.4
X76 OTA_0.XM17.D0 OTA_0.vc OTA_0.XM15.D vss sky130_fd_pr__nfet_01v8 ad=3.48 pd=24.58 as=1.74 ps=12.29 w=12 l=0.4
X77 OTA_0.XM23.D0 vip OTA_0.XM21.D0 vss sky130_fd_pr__nfet_01v8 ad=1.74 pd=12.29 as=3.48 ps=24.58 w=12 l=0.4
X78 OTA_0.XM15.D OTA_0.vc OTA_0.XM17.D0 vss sky130_fd_pr__nfet_01v8 ad=1.74 pd=12.29 as=1.74 ps=12.29 w=12 l=0.4
X79 OTA_0.XM23.D0 vip OTA_0.XM21.D0 vss sky130_fd_pr__nfet_01v8 ad=1.74 pd=12.29 as=1.74 ps=12.29 w=12 l=0.4
X80 OTA_0.XM22.D0 OTA_0.va vdd vdd sky130_fd_pr__pfet_01v8 ad=0.58 pd=4.29 as=0.58 ps=4.29 w=4 l=0.4
X81 OTA_0.XM17.D0 OTA_0.vb OTA_0.XM21.D0 vdd sky130_fd_pr__pfet_01v8 ad=1.74 pd=12.29 as=1.74 ps=12.29 w=12 l=0.4
X82 OTA_0.XM16.D OTA_0.vc vout vss sky130_fd_pr__nfet_01v8 ad=1.74 pd=12.29 as=1.74 ps=12.29 w=12 l=0.4
X83 OTA_0.XM23.D0 vip OTA_0.XM21.D0 vss sky130_fd_pr__nfet_01v8 ad=1.74 pd=12.29 as=1.74 ps=12.29 w=12 l=0.4
X84 OTA_0.XM15.D OTA_0.vc OTA_0.XM17.D0 vss sky130_fd_pr__nfet_01v8 ad=1.74 pd=12.29 as=1.74 ps=12.29 w=12 l=0.4
X85 Beta_mult_0.XR1.R1 Beta_mult_0.XM31.S OTA_0.vdo vss sky130_fd_pr__nfet_01v8 ad=2.32 pd=16.58 as=2.32 ps=16.58 w=8 l=0.4
X86 OTA_0.XM21.D0 vip OTA_0.XM23.D0 vss sky130_fd_pr__nfet_01v8 ad=1.74 pd=12.29 as=1.74 ps=12.29 w=12 l=0.4
X87 OTA_0.XM17.D0 OTA_0.vc OTA_0.XM15.D vss sky130_fd_pr__nfet_01v8 ad=1.74 pd=12.29 as=1.74 ps=12.29 w=12 l=0.4
X88 OTA_0.XM21.D0 vip OTA_0.XM23.D0 vss sky130_fd_pr__nfet_01v8 ad=3.48 pd=24.58 as=1.74 ps=12.29 w=12 l=0.4
X89 OTA_0.XM17.D0 OTA_0.vc OTA_0.XM15.D vss sky130_fd_pr__nfet_01v8 ad=1.74 pd=12.29 as=1.74 ps=12.29 w=12 l=0.4
X90 OTA_0.XM22.D0 OTA_0.vb vout vdd sky130_fd_pr__pfet_01v8 ad=1.74 pd=12.29 as=1.74 ps=12.29 w=12 l=0.4
X91 OTA_0.XM21.D0 OTA_0.vb OTA_0.XM17.D0 vdd sky130_fd_pr__pfet_01v8 ad=1.74 pd=12.29 as=1.74 ps=12.29 w=12 l=0.4
X92 vout OTA_0.vc OTA_0.XM16.D vss sky130_fd_pr__nfet_01v8 ad=1.74 pd=12.29 as=1.74 ps=12.29 w=12 l=0.4
X93 vout OTA_0.vc OTA_0.XM16.D vss sky130_fd_pr__nfet_01v8 ad=3.48 pd=24.58 as=1.74 ps=12.29 w=12 l=0.4
X94 OTA_0.XM16.D OTA_0.vc vout vss sky130_fd_pr__nfet_01v8 ad=1.74 pd=12.29 as=1.74 ps=12.29 w=12 l=0.4
X95 OTA_0.XM22.D0 OTA_0.va vdd vdd sky130_fd_pr__pfet_01v8 ad=1.16 pd=8.58 as=0.58 ps=4.29 w=4 l=0.4
X96 OTA_0.XM23.D0 vip OTA_0.XM21.D0 vss sky130_fd_pr__nfet_01v8 ad=1.74 pd=12.29 as=1.74 ps=12.29 w=12 l=0.4
X97 OTA_0.XM17.D0 OTA_0.vb OTA_0.XM21.D0 vdd sky130_fd_pr__pfet_01v8 ad=1.74 pd=12.29 as=1.74 ps=12.29 w=12 l=0.4
X98 OTA_0.XM15.D OTA_0.vc OTA_0.XM17.D0 vss sky130_fd_pr__nfet_01v8 ad=1.74 pd=12.29 as=1.74 ps=12.29 w=12 l=0.4
X99 OTA_0.XM17.D0 OTA_0.vb OTA_0.XM21.D0 vdd sky130_fd_pr__pfet_01v8 ad=3.48 pd=24.58 as=1.74 ps=12.29 w=12 l=0.4
X100 vdd OTA_0.va OTA_0.XM21.D0 vdd sky130_fd_pr__pfet_01v8 ad=0.58 pd=4.29 as=0.58 ps=4.29 w=4 l=0.4
X101 OTA_0.XM16.D OTA_0.vc vout vss sky130_fd_pr__nfet_01v8 ad=1.74 pd=12.29 as=1.74 ps=12.29 w=12 l=0.4
X102 vss OTA_0.XM34.S OTA_0.XM34.S vss sky130_fd_pr__nfet_01v8 ad=0.464 pd=3.78 as=0.464 ps=3.78 w=1.6 l=0.4
X103 vout OTA_0.vc OTA_0.XM16.D vss sky130_fd_pr__nfet_01v8 ad=1.74 pd=12.29 as=1.74 ps=12.29 w=12 l=0.4
X104 OTA_0.XM21.D0 OTA_0.vb OTA_0.XM17.D0 vdd sky130_fd_pr__pfet_01v8 ad=1.74 pd=12.29 as=1.74 ps=12.29 w=12 l=0.4
X105 vout OTA_0.vc OTA_0.XM16.D vss sky130_fd_pr__nfet_01v8 ad=1.74 pd=12.29 as=1.74 ps=12.29 w=12 l=0.4
X106 OTA_0.XM21.D0 OTA_0.vb OTA_0.XM17.D0 vdd sky130_fd_pr__pfet_01v8 ad=1.74 pd=12.29 as=1.74 ps=12.29 w=12 l=0.4
X107 OTA_0.XM21.D0 OTA_0.va vdd vdd sky130_fd_pr__pfet_01v8 ad=0.58 pd=4.29 as=0.58 ps=4.29 w=4 l=0.4
X108 vout OTA_0.vc OTA_0.XM16.D vss sky130_fd_pr__nfet_01v8 ad=1.74 pd=12.29 as=1.74 ps=12.29 w=12 l=0.4
X109 vss biasing_0.VD biasing_0.XM8.D vss sky130_fd_pr__nfet_01v8 ad=0.174 pd=1.78 as=0.174 ps=1.78 w=0.6 l=0.4
X110 biasing_0.XM8.D OTA_0.vc OTA_0.vb vss sky130_fd_pr__nfet_01v8 ad=2.32 pd=16.58 as=2.32 ps=16.58 w=8 l=0.4
X111 OTA_0.XM17.D0 OTA_0.vb OTA_0.XM21.D0 vdd sky130_fd_pr__pfet_01v8 ad=1.74 pd=12.29 as=1.74 ps=12.29 w=12 l=0.4
X112 OTA_0.XM22.D0 OTA_0.va vdd vdd sky130_fd_pr__pfet_01v8 ad=0.58 pd=4.29 as=0.58 ps=4.29 w=4 l=0.4
X113 vdd Beta_mult_0.XM31.G Beta_mult_0.XM31.G vdd sky130_fd_pr__pfet_01v8 ad=0.58 pd=4.58 as=0.58 ps=4.58 w=2 l=20
X114 OTA_0.XM15.D OTA_0.vc OTA_0.XM17.D0 vss sky130_fd_pr__nfet_01v8 ad=1.74 pd=12.29 as=3.48 ps=24.58 w=12 l=0.4
X115 vout OTA_0.vb OTA_0.XM22.D0 vdd sky130_fd_pr__pfet_01v8 ad=1.74 pd=12.29 as=1.74 ps=12.29 w=12 l=0.4
X116 OTA_0.XM16.D OTA_0.vc vout vss sky130_fd_pr__nfet_01v8 ad=1.74 pd=12.29 as=1.74 ps=12.29 w=12 l=0.4
X117 OTA_0.XM17.D0 OTA_0.vb OTA_0.XM21.D0 vdd sky130_fd_pr__pfet_01v8 ad=1.74 pd=12.29 as=1.74 ps=12.29 w=12 l=0.4
.ends
